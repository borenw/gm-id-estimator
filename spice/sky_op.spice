* sky130 nfet_01v8 operating-point sweep — Id, gm, gds(→ro), vth, cgg(→cg) vs Vgs
* Reference device W=10 L=0.15 (Vds=0.9, tt). Used to build the gm/Id sim lookup in the tool.
* Run:  PDK_ROOT=~/.volare/volare/sky130/versions/<hash>  ngspice -b sky_op.spice
.lib "$PDK_ROOT/sky130A/libs.tech/ngspice/sky130.lib.spice" tt
Vg g 0 0
Vd d 0 0.9
X1 d g 0 0 sky130_fd_pr__nfet_01v8 L=0.15 W=10 nf=1
.control
save @m.x1.msky130_fd_pr__nfet_01v8[id] @m.x1.msky130_fd_pr__nfet_01v8[gm] @m.x1.msky130_fd_pr__nfet_01v8[gds] @m.x1.msky130_fd_pr__nfet_01v8[vth] @m.x1.msky130_fd_pr__nfet_01v8[cgg]
dc Vg 0 1.8 0.02
let id  = @m.x1.msky130_fd_pr__nfet_01v8[id]
let gm  = @m.x1.msky130_fd_pr__nfet_01v8[gm]
let gds = @m.x1.msky130_fd_pr__nfet_01v8[gds]
let vth = @m.x1.msky130_fd_pr__nfet_01v8[vth]
let cgg = @m.x1.msky130_fd_pr__nfet_01v8[cgg]
wrdata sky_op.txt id gm gds vth cgg
.endc
.end
